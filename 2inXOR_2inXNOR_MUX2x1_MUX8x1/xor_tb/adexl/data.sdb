ADE simulation setup
Run mode: Single Run, Sweeps and Corners
Tests:
  Boma:xor_tb:1: Boma/xor_tb/schematic, simulator spectre
Global variables:
  Vin1 = 0
  Vin2 = 0
