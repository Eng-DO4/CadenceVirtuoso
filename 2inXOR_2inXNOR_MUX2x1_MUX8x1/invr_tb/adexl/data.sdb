ADE simulation setup
Run mode: Single Run, Sweeps and Corners
Tests:
  Boma:invr_tb:1: Boma/invr_tb/schematic, simulator spectre
Global variables:
  Vin = 0
