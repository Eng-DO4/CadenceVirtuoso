ADE simulation setup
Run mode: Single Run, Sweeps and Corners
Tests:
  Boma:mux_8x1_tb:1: Boma/mux_8x1_tb/schematic, simulator spectre
Global variables:
  Vin0 = 0
  Vin1 = 0
  Vin2 = 0
  Vin3 = 0
  Vin4 = 0
  Vin5 = 0
  Vin6 = 0
  Vin7 = 0
  Vs0 = 0
  Vs1 = 0
  Vs2 = 0
