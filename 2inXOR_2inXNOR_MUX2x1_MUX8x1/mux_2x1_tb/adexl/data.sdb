ADE simulation setup
Run mode: Single Run, Sweeps and Corners
Tests:
  Boma:mux_2x1_tb:1: Boma/mux_2x1_tb/schematic, simulator spectre
Global variables:
  Vin1 = 0
  Vin2 = 0
  Vs = 0
